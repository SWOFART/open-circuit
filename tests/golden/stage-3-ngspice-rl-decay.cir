* Open Circuit Stage 3 RL current-decay reference; ngspice 36.
R1 a 0 10
L1 a 0 100m IC=1
.control
set numdgt=15
tran 10u 50m 0 10u uic
meas tran current_10ms find i(L1) at=10m
meas tran current_20ms find i(L1) at=20m
meas tran current_30ms find i(L1) at=30m
quit
.endc
.end
