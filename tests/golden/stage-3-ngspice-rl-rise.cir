* Open Circuit Stage 3 RL current-rise reference; ngspice 36.
V1 in 0 DC 10
R1 in mid 10
L1 mid 0 100m IC=0
.control
set numdgt=15
tran 10u 50m 0 10u uic
meas tran current_10ms find i(L1) at=10m
meas tran current_20ms find i(L1) at=20m
meas tran current_30ms find i(L1) at=30m
quit
.endc
.end
