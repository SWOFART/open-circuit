* Stage 7 reference circuit: npn-active
* NPN forward active: base source 5 V, 430 kOhm.
.options temp=27 tnom=27 gmin=0 reltol=1e-9 vntol=1e-12 abstol=1e-15 itl1=500 itl2=500
VCC vcc 0 10
VBB vbb 0 5
RC vcc c 1000
RB vbb b 430000
VSC c tc 0
VSB b tb 0
VSE 0 te 0
Q1 tc tb te QM
RGBE tb te 1e12
RGBC tb tc 1e12
.model QM NPN(IS=1e-14 BF=100 BR=1)
.control
op
wrdata npn-active.out v(b) v(c) i(vsc) i(vsb) i(vse)
.endc
.end
