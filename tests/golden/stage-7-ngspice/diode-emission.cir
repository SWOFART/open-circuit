* Stage 7 reference circuit: diode-emission
* Non-default model: I_S = 1e-12 A, n = 1.8 (5 V, 1 kOhm).
.options temp=27 tnom=27 gmin=0 reltol=1e-9 vntol=1e-12 abstol=1e-15 itl1=500 itl2=500
VSRC s 0 5
RS s a 1000
D1 a 0 DM
RGD a 0 1e12
.model DM D(IS=1e-12 N=1.8)
.control
op
wrdata diode-emission.out v(a) i(vsrc)
.endc
.end
