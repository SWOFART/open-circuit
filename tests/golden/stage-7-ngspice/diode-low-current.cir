* Stage 7 reference circuit: diode-low-current
* Supported but hard: forward at about 0.2 uA (0.6 V, 1 MOhm).
.options temp=27 tnom=27 gmin=0 reltol=1e-9 vntol=1e-12 abstol=1e-15 itl1=500 itl2=500
VSRC s 0 0.6
RS s a 1000000
D1 a 0 DM
RGD a 0 1e12
.model DM D(IS=1e-14 N=1)
.control
op
wrdata diode-low-current.out v(a) i(vsrc)
.endc
.end
