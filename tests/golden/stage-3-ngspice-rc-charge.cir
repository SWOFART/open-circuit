* Open Circuit Stage 3 RC charge reference; ngspice 36.
V1 in 0 DC 10
R1 in out 1k
C1 out 0 10u IC=0
.control
set numdgt=15
tran 10u 50m 0 10u uic
meas tran voltage_10ms find v(out) at=10m
meas tran voltage_20ms find v(out) at=20m
meas tran voltage_30ms find v(out) at=30m
quit
.endc
.end
