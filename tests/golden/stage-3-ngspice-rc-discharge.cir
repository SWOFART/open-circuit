* Open Circuit Stage 3 RC discharge reference; ngspice 36.
R1 out 0 1k
C1 out 0 10u IC=10
.control
set numdgt=15
tran 10u 50m 0 10u uic
meas tran voltage_10ms find v(out) at=10m
meas tran voltage_20ms find v(out) at=20m
meas tran voltage_30ms find v(out) at=30m
quit
.endc
.end
