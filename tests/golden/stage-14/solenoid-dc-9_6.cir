Open Circuit Stage 14: solenoid-dc-9_6
.options reltol=1e-9 abstol=1e-13 vntol=1e-10 temp=27 tnom=27
Vin input 0 9.6
Vsense input p 0
Rpart p 0 24
.op
.control
set noaskquit
set numdgt=16
set wr_singlescale
run
let sample0 = v(p)
let sample1 = i(vsense)
wrdata values.out sample0 sample1
quit
.endc
.end
