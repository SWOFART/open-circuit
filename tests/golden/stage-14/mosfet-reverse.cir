Open Circuit Stage 14: mosfet-reverse
.options reltol=1e-9 abstol=1e-13 vntol=1e-10 temp=27 tnom=27
Vgate gate 0 4
Vdrain input 0 -1
Vsense input d 0
Mref 0 gate d d Ref W=1u L=1u
.model Ref NMOS(Level=1 Vto=2 Kp=0.1 Is=1e-30)
.op
.control
set noaskquit
set numdgt=16
set wr_singlescale
run
let sample0 = v(gate)
let sample1 = v(d)
let sample2 = i(vsense)
wrdata values.out sample0 sample1 sample2
quit
.endc
.end
