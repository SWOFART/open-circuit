Open Circuit Stage 14: selector-right
.options reltol=1e-9 abstol=1e-13 vntol=1e-10 temp=27 tnom=27
Vin com 0 24
Vprobe1 com feed1 0
Rload1 out1 0 120
Vprobe2 com feed2 0
Rload2 out2 0 120
Rcontact2 feed2 out2 0.01
.op
.control
set noaskquit
set numdgt=16
set wr_singlescale
run
let sample0 = v(com,out1)
let sample1 = i(vprobe1)
let sample2 = v(com,out2)
let sample3 = i(vprobe2)
wrdata values.out sample0 sample1 sample2 sample3
quit
.endc
.end
