Open Circuit Stage 10 reference: star-delta-swapped
.options method=trap reltol=1e-9 vntol=1e-10 abstol=1e-12 temp=27 tnom=27
vline0 l0 0 sin(0 67.88225099390857 50 0 0 0)
vline1 l1 0 sin(0 67.88225099390857 50 0 0 120)
vline2 l2 0 sin(0 67.88225099390857 50 0 0 -120)
vstar star 0 pwl(0 0 0.020957600000000003 0 0.020959600000000002 1 0.12096219999999999 1 0.1209642 0 0.14095760000000002 0 0.14095960000000002 0)
vdelta delta 0 pwl(0 0 0.020957600000000003 0 0.020959600000000002 0 0.12096219999999999 0 0.1209642 0 0.14095760000000002 0 0.14095960000000002 1)
bsa sa 0 v=(0.10500000000000001*v(fsa)-0.1*v(fra))/0.0010249999999999999
bsb sb 0 v=(0.10500000000000001*v(fsb)-0.1*v(frb))/0.0010249999999999999
bra ra 0 v=(0.10500000000000001*v(fra)-0.1*v(fsa))/0.0010249999999999999
brb rb 0 v=(0.10500000000000001*v(frb)-0.1*v(fsb))/0.0010249999999999999
bcu cu 0 v=v(sa)
bcv cv 0 v=(-v(sa)+1.7320508075688772*v(sb))/2
bcw cw 0 v=(-v(sa)-1.7320508075688772*v(sb))/2
bvu vu 0 v=v(star)*((v(l0)-0.025*v(cu))/1.0025)+v(delta)*((v(l0,l1)-0.055*v(cu))/1.0055)-(1-v(star)-v(delta))*10*v(cu)
bvv vv 0 v=v(star)*((v(l1)-0.025*v(cv))/1.0025)+v(delta)*((v(l1,l2)-0.055*v(cv))/1.0055)-(1-v(star)-v(delta))*10*v(cv)
bvw vw 0 v=v(star)*((v(l2)-0.025*v(cw))/1.0025)+v(delta)*((v(l2,l0)-0.055*v(cw))/1.0055)-(1-v(star)-v(delta))*10*v(cw)
bload0 l0 0 i=v(star)*(v(cu)+v(vu)/10)+v(delta)*((v(cu)+v(vu)/10)-(v(cw)+v(vw)/10))
bload1 l1 0 i=v(star)*(v(cv)+v(vv)/10)+v(delta)*((v(cv)+v(vv)/10)-(v(cu)+v(vu)/10))
bload2 l2 0 i=v(star)*(v(cw)+v(vw)/10)+v(delta)*((v(cw)+v(vw)/10)-(v(cv)+v(vv)/10))
bfsalpha 0 fsa i=v(vu)-1*v(sa)
bfsbeta 0 fsb i=(v(vv)-v(vw))/1.7320508075688772-1*v(sb)
bfralpha 0 fra i=-1*v(ra)-2*v(speed)*v(frb)
bfrbeta 0 frb i=-1*v(rb)+2*v(speed)*v(fra)
cfsa fsa 0 1 ic=0
cfsb fsb 0 1 ic=0
cfra fra 0 1 ic=0
cfrb frb 0 1 ic=0
btorque torque 0 v=0.30000000000000004*(v(ra)*v(sb)-v(rb)*v(sa))
bshaft 0 speed i=(v(torque)-0.01*v(speed)-0.1)/0.002
cspeed speed 0 1 ic=0
.tran 0.00001 0.25 0 0.00001 uic
.control
set noaskquit
set numdgt=16
set wr_singlescale
run
wrdata star-delta-swapped.out v(cu) v(cv) v(cw) v(speed) v(torque) i(vline0) i(vline2) i(vline1)
quit
.endc
.end
