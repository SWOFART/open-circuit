* Stage 9 reference circuit: rlc-60-phase-90
* series_rlc, 60 Hz, phase 90 degrees; closed-form startup and steady state.
V1 src 0 SIN(0 14.14213562373095 60.00000000000000 0 0 90.00000000000000)
Rsource src n1 0.1000000000000000
Rload n1 n2 20.00000000000000
L1 n2 n3 0.1000000000000000 IC=0
C1 n3 0 0.0001000000000000000 IC=14.14213562373095
.options temp=27 tnom=27 gmin=0 method=trap reltol=1e-10 vntol=1e-12 abstol=1e-14 savecurrents
.control
tran 0.00005000000000000000 0.2166666666666667 0 0.000001000000000000000 uic
set wr_singlescale
wrdata rlc-60-phase-90.out v(src) v(n1) v(n2) v(n3) @rsource[i] @rload[i] @l1[i] @c1[i]
.endc
.end
