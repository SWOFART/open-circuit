* Stage 9 reference circuit: rc-400-phase-0
* series_rc, 400 Hz, phase 0 degrees; closed-form startup and steady state.
V1 src 0 SIN(0 14.14213562373095 400.0000000000000 0 0 0)
Rsource src n1 0.1000000000000000
Rload n1 cap 100.0000000000000
C1 cap 0 0.0001000000000000000 IC=0
.options temp=27 tnom=27 gmin=0 method=trap reltol=1e-10 vntol=1e-12 abstol=1e-14 savecurrents
.control
tran 0.00005000000000000000 0.2025000000000000 0 0.000001000000000000000 uic
set wr_singlescale
wrdata rc-400-phase-0.out v(src) v(n1) v(cap) @rsource[i] @rload[i] @c1[i]
.endc
.end
