* Stage 9 reference circuit: rl-50-phase-90
* series_rl, 50 Hz, phase 90 degrees; closed-form startup and steady state.
V1 src 0 SIN(0 14.14213562373095 50.00000000000000 0 0 90.00000000000000)
Rsource src n1 0.1000000000000000
Rload n1 n2 100.0000000000000
L1 n2 0 0.1000000000000000 IC=0.1412800761611484
.options temp=27 tnom=27 gmin=0 method=trap reltol=1e-10 vntol=1e-12 abstol=1e-14 savecurrents
.control
tran 0.00005000000000000000 0.2200000000000000 0 0.000001000000000000000 uic
set wr_singlescale
wrdata rl-50-phase-90.out v(src) v(n1) v(n2) @rsource[i] @rload[i] @l1[i]
.endc
.end
