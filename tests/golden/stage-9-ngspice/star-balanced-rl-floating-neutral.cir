* Stage 9 reference circuit: star-balanced-rl-floating-neutral
* Balanced three-phase star RL loads with a floating load neutral.
Rsource_l1 l1 src_l1 0.1000000000000000
V1 src_l1 0 SIN(0 325.2691193458119 50.00000000000000 0 0 0)
Rsource_l2 l2 src_l2 0.1000000000000000
V2 src_l2 0 SIN(0 325.2691193458119 50.00000000000000 0 0 -120.0000000000000)
Rsource_l3 l3 src_l3 0.1000000000000000
V3 src_l3 0 SIN(0 325.2691193458119 50.00000000000000 0 0 120.0000000000000)
Rphase1 l1 mid_phase1 100.0000000000000
Lphase1 mid_phase1 nload 0.1000000000000000
Rphase2 l2 mid_phase2 100.0000000000000
Lphase2 mid_phase2 nload 0.1000000000000000
Rphase3 l3 mid_phase3 100.0000000000000
Lphase3 mid_phase3 nload 0.1000000000000000
.options temp=27 tnom=27 gmin=0 method=trap reltol=1e-10 vntol=1e-12 abstol=1e-14 savecurrents
.control
tran 0.00005000000000000000 0.1200000000000000 0 0.000001000000000000000 uic
set wr_singlescale
wrdata star-balanced-rl-floating-neutral.out v(l1) v(l2) v(l3) v(mid_phase1) v(mid_phase2) v(mid_phase3) v(nload) v(src_l1) v(src_l2) v(src_l3) @rsource_l1[i] @rsource_l2[i] @rsource_l3[i] @rphase1[i] @lphase1[i] @rphase2[i] @lphase2[i] @rphase3[i] @lphase3[i]
.endc
.end
