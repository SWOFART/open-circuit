* Stage 9 reference circuit: wattmeter-rl-reversed-current
* RL wattmeter, 50 Hz; current orientation reversed wrong variant.
V1 src 0 SIN(0 14.14213562373095 50.00000000000000 0 0 0)
Rsource src n1 0.1000000000000000
Rburden n1 n2 0.1000000000000000
Rload n2 n3 100.0000000000000
L1 n3 0 0.1000000000000000
Rinput n2 0 10000000.00000000
.options temp=27 tnom=27 gmin=0 method=trap reltol=1e-10 vntol=1e-12 abstol=1e-14 savecurrents
.control
tran 0.00005000000000000000 0.3000000000000000 0 0.000001000000000000000 uic
set wr_singlescale
wrdata wattmeter-rl-reversed-current.out v(src) v(n1) v(n2) v(n3) @rsource[i] @rburden[i] @rload[i] @l1[i] @rinput[i]
.endc
.end
